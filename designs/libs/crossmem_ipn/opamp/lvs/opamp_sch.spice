** sch_path: /foss/designs/ElectronicaAnalogicaUPIITA/Proyecto/opamp.sch
.subckt opamp vdd vin1 vin2 vout iref vss
*.PININFO vss:B vdd:B vout:O iref:I vin1:I vin2:I
XM3 net1 net1 vdd vdd sky130_fd_pr__pfet_01v8 L=1 W=9 nf=1 ad=2.61 as=2.61 pd=18.58 ps=18.58 nrd=0.0322222222222222
+ nrs=0.0322222222222222 sa=0 sb=0 sd=0 mult=1 m=1
XM4 net2 net1 vdd vdd sky130_fd_pr__pfet_01v8 L=1 W=9 nf=1 ad=2.61 as=2.61 pd=18.58 ps=18.58 nrd=0.0322222222222222
+ nrs=0.0322222222222222 sa=0 sb=0 sd=0 mult=1 m=1
XM6 vout net2 vdd vdd sky130_fd_pr__pfet_01v8 L=1 W=8.65 nf=20 ad=1.25425 as=1.379675 pd=14.45 ps=15.895 nrd=0.0335260115606936
+ nrs=0.0335260115606936 sa=0 sb=0 sd=0 mult=1 m=1
XM1 net1 vin1 net3 vss sky130_fd_pr__nfet_01v8 L=1 W=5 nf=1 ad=1.45 as=1.45 pd=10.58 ps=10.58 nrd=0.058 nrs=0.058 sa=0 sb=0 sd=0
+ mult=1 m=1
XM2 net2 vin2 net3 vss sky130_fd_pr__nfet_01v8 L=1 W=5 nf=1 ad=1.45 as=1.45 pd=10.58 ps=10.58 nrd=0.058 nrs=0.058 sa=0 sb=0 sd=0
+ mult=1 m=1
XM5 net3 iref vss vss sky130_fd_pr__nfet_01v8 L=1 W=8 nf=1 ad=2.32 as=2.32 pd=16.58 ps=16.58 nrd=0.03625 nrs=0.03625 sa=0 sb=0
+ sd=0 mult=1 m=1
XM8 iref iref vss vss sky130_fd_pr__nfet_01v8 L=1 W=8 nf=1 ad=2.32 as=2.32 pd=16.58 ps=16.58 nrd=0.03625 nrs=0.03625 sa=0 sb=0
+ sd=0 mult=1 m=1
XM7 vout iref vss vss sky130_fd_pr__nfet_01v8 L=1 W=7 nf=16 ad=1.015 as=1.141875 pd=11.64 ps=13.095 nrd=0.0414285714285714
+ nrs=0.0414285714285714 sa=0 sb=0 sd=0 mult=1 m=1
XC1 net2 vout sky130_fd_pr__cap_mim_m3_1 W=38.73 L=38.73 MF=1 m=1
.ends
